QS30 A9.2 diagnostic startup_9
* Generated from native netlist; see manifest and MODEL_LIMITS.md
.options reltol=0.003 abstol=1n vntol=10u method=gear itl4=200
.param beta=100
.model NGEN NPN(IS=6.7f BF={beta} VAF=75 IKF=.1 ISE=6.7f NE=1.5 BR=4 RB=10 RC=1 RE=.5 CJE=4p CJC=3p TF=.3n TR=100n)
.model PGEN PNP(IS=14f BF={beta} VAF=50 IKF=.1 BR=4 RB=10 RC=1 RE=.5 CJE=5p CJC=4p TF=.5n TR=100n)
.model UFGEN D(IS=10n N=1.5 RS=.5 CJO=15p TT=75n BV=1000 IBV=5u)
.model SCHGEN D(IS=200n N=1.05 RS=2 CJO=10p BV=30 IBV=2u)
.model P_SW SW(RON=.098 ROFF=1g VT=2 VH=.05)
.model N_SW SW(RON=.55 ROFF=1g VT=2.5 VH=.1)
VIN input 0 PWL(0 0 100u 12)
R_FIXTURE input EXT12 .5
V3V3 3V3 0 PWL(0 0 500u 3.3)
VREQUEST HV_EN_REQ 0 PWL(0 0 1m 0 1.001m 3.3)
RSTAR GND_HV 0 .001
VRST OVP_RST 0 0
R17 EXT12 VREF_2V5 4.7k
R18 VREF_2V5 VREF_1V0 15k
R19 VREF_1V0 0 10k
C8 VREF_1V0 0 100nF
R20 DRV_VDD DRV_SNS 102k
R21 DRV_SNS 0 10k
R22 DRV_SNS DRV_PG 1M
R23 DRV_PG 3V3 10k
R24 FAULT_OK 3V3 10k
R25 EXT12 EXT12_SNS 100k
R26 EXT12_SNS 0 10.5k
R27 3V3 P3V3_SNS 30.1k
R28 P3V3_SNS 0 14.3k
R29 EXT12_PG 3V3 10k
R30 P3V3_PG 3V3 10k
R38 HV_EN_G EXT12 100k
R38B HV_EN Q5_B 10k
R40 EXT12 VREF_OVP 4.7k
R41 HV_BUS OVP_SNS 1500k
R42 OVP_SNS 0 19.1k
C16 OVP_SNS 0 100nF
R43 OVP_SET EXT12 10k
R44 LATCH_B EXT12 100k
R45 OVP_SET LATCH_B 10k
R46 OVP_LATCH 0 100k
R47 OVP_LATCH Q23_B 47k
R48 OVP_LATCH Q24_B 47k
R49 HV_FAULT_OD EXT12 10k
R50 HV_FAULT_OD HVF_NODE 100k
R51 HVF_NODE 0 12k
R52 OVP_RST OVP_RST_G 10k
R53 OVP_RST_G 0 100k
R15 DRV_VDD_G EXT12 100k
R16 DRV_VDD_EN Q3_B 10k
R_Q5_BE Q5_B 0 100k
R_Q3_BE Q3_B 0 100k
R_HV_REQ_PD HV_EN_REQ 0 100k
BU6_SHUNT VREF_2V5 0 I=max((v(VREF_2V5)-2.495)/.2,0)
CU6_PAR VREF_2V5 0 100p
BU24_SHUNT VREF_OVP 0 I=max((v(VREF_OVP)-2.495)/.2,0)
CU24_PAR VREF_OVP 0 100p
BOVP_DIFF OVP_raw 0 V=v(VREF_OVP)-v(OVP_SNS)
ROVP_DELAY OVP_raw OVP_ctl 1k
COVP_DELAY OVP_ctl 0 1n
BOVP_OUT OVP_SET 0 I=(v(EXT12)>2 && v(OVP_ctl)<0) ? max(v(OVP_SET),0)/50 : 0
BDPG_DIFF DPG_raw 0 V=v(DRV_SNS)-v(VREF_1V0)
RDPG_DELAY DPG_raw DPG_ctl 1k
CDPG_DELAY DPG_ctl 0 1n
BDPG_OUT DRV_PG 0 I=(v(3V3)>2 && v(DPG_ctl)<0) ? max(v(DRV_PG),0)/50 : 0
BFOK_DIFF FOK_raw 0 V=v(HVF_NODE)-v(VREF_1V0)
RFOK_DELAY FOK_raw FOK_ctl 1k
CFOK_DELAY FOK_ctl 0 1n
BFOK_OUT FAULT_OK 0 I=(v(3V3)>2 && v(FOK_ctl)<0) ? max(v(FAULT_OK),0)/50 : 0
BEPG_DIFF EPG_raw 0 V=v(EXT12_SNS)-v(VREF_1V0)
REPG_DELAY EPG_raw EPG_ctl 1k
CEPG_DELAY EPG_ctl 0 1n
BEPG_OUT EXT12_PG 0 I=(v(3V3)>2 && v(EPG_ctl)<0) ? max(v(EXT12_PG),0)/50 : 0
B3PG_DIFF 3PG_raw 0 V=v(P3V3_SNS)-v(VREF_1V0)
R3PG_DELAY 3PG_raw 3PG_ctl 1k
C3PG_DELAY 3PG_ctl 0 1n
B3PG_OUT P3V3_PG 0 I=(v(3V3)>2 && v(3PG_ctl)<0) ? max(v(P3V3_PG),0)/50 : 0
D4_LOWER 0 HVF_NODE SCHGEN
D4_UPPER HVF_NODE 3V3 SCHGEN
Q21 OVP_LATCH LATCH_B EXT12 PGEN
Q22 LATCH_B OVP_LATCH 0 NGEN
Q23 COMP_N Q23_B 0 NGEN
Q24 HV_FAULT_OD Q24_B 0 NGEN
Q25 OVP_LATCH OVP_RST_G 0 NGEN
Q5 HV_EN_G Q5_B 0 NGEN
Q3 DRV_VDD_G Q3_B 0 NGEN
C_Q4_GATE HV_EN_G EXT12 1n
C_Q2_GATE DRV_VDD_G EXT12 1n
S_Q4 HV_IN EXT12 EXT12 HV_EN_G P_SW
S_Q2 DRV_VDD EXT12 EXT12 DRV_VDD_G P_SW
R_HVIN_LOAD HV_IN 0 20k
C_HVIN HV_IN 0 1u
R_DRV_LOAD DRV_VDD 0 5k
C_DRV DRV_VDD 0 1u
B_DRV_EN DRV_VDD_EN 0 V=(v(EXT12_PG)>2 && v(P3V3_PG)>2 && v(HV_EN_REQ)>2) ? v(3V3) : 0
B_HV_EN HV_EN 0 V=(v(DRV_PG)>2 && v(FAULT_OK)>2 && v(HV_EN_REQ)>2 && v(3V3)>3) ? v(3V3) : 0
R31 EXT12 VREF_AUX_2V5 4.7k
R32 RT_CT VREF_UC 10k
C9 RT_CT 0 2.2nF
R37 COMP_N COMP_R 10k
C14 COMP_R 0 100nF
C15 COMP_N 0 22uF
.model UV_SW SW(RON=1 ROFF=1g VT=8 VH=.4)
V_ONE ONE 0 1
S_UVLO ONE UC_OK HV_IN 0 UV_SW
R_UVLO UC_OK 0 1k
C_UCREF_INTERNAL VREF_UC 0 10n
B_UCREF 0 VREF_UC I=(v(UC_OK)>.5) ? min(max((5-v(VREF_UC))/.1,0),.05) : 0
R_UCREF_LEAK VREF_UC 0 100k
B_U21 VREF_AUX_2V5 0 I=max((v(VREF_AUX_2V5)-2.495)/.2,0)
B_COMP 0 COMP_N I=(v(UC_OK)>.5) ? min(max((2.5-v(FB_HV))*.002,-.0005),.0005) : 0
R_COMP_LEAK COMP_N 0 1meg
R_L_DCR HV_IN L_IN .3
L20 L_IN SW_HV 220u
S_Q20 SW_HV Q20_SOURCE HV_GATE 0 N_SW
VQ20_SENSE Q20_SOURCE 0 0
D20 SW_HV HV_BUS UFGEN
C10 SW_HV HV_BUS 10nF
C11 HV_BUS GND_HV 10uF
C12 HV_BUS GND_HV 10uF
R33 HV_BUS GND_HV 200k
C_MODULES HV_BUS GND_HV 300n
R_MODULES HV_BUS GND_HV 66.6666667k
R36 SW_HV CS_FILT 100k
C13 CS_FILT 0 470pF
R34 HV_BUS FB_HV 1500k
R35 FB_HV 0 22.1k
B_RAMP RAMP 0 V=(time*78000-floor(time*78000))
B_UCOUT HV_GATE 0 V=(v(UC_OK)>.5 && v(VREF_UC)>4.5 && v(COMP_N)>1.4 && v(CS_FILT)<min(max((v(COMP_N)-1.4)/3,0),1) && v(RAMP)<.92) ? 10 : 0
B_TUBE1 HV_BUS 0 I=(1<=(9)) ? max((v(HV_BUS)-125)/20000,0) : 0
B_TUBE2 HV_BUS 0 I=(2<=(9)) ? max((v(HV_BUS)-125)/20000,0) : 0
B_TUBE3 HV_BUS 0 I=(3<=(9)) ? max((v(HV_BUS)-125)/20000,0) : 0
B_TUBE4 HV_BUS 0 I=(4<=(9)) ? max((v(HV_BUS)-125)/20000,0) : 0
B_TUBE5 HV_BUS 0 I=(5<=(9)) ? max((v(HV_BUS)-125)/20000,0) : 0
B_TUBE6 HV_BUS 0 I=(6<=(9)) ? max((v(HV_BUS)-125)/20000,0) : 0
B_TUBE7 HV_BUS 0 I=(7<=(9)) ? max((v(HV_BUS)-125)/20000,0) : 0
B_TUBE8 HV_BUS 0 I=(8<=(9)) ? max((v(HV_BUS)-125)/20000,0) : 0
B_TUBE9 HV_BUS 0 I=(9<=(9)) ? max((v(HV_BUS)-125)/20000,0) : 0
.save all @q21[ic] @q22[ic] @q25[ic]
.control
set noaskquit
set wr_singlescale
set wr_vecnames
tran 10u 0.08 0 1u uic
meas tran q21_peak MIN @q21[ic]
meas tran q22_peak MAX @q22[ic]
meas tran hv_peak MAX v(HV_BUS)
meas tran end_time MAX time
meas tran hv_mean AVG v(HV_BUS) FROM=60m TO=80m
meas tran hv_pp PP v(HV_BUS) FROM=60m TO=80m
let vds = v(SW_HV)-v(Q20_SOURCE)
meas tran vds_peak MAX vds
meas tran id_peak MAX i(VQ20_SENSE)
meas tran il_peak MAX i(L20)
let vreverse = v(HV_BUS)-v(SW_HV)
meas tran diode_reverse MAX vreverse
meas tran cap_peak MAX v(HV_BUS)
let pin = -v(input)*i(VIN)
meas tran input_power AVG pin FROM=60m TO=80m
linearize v(HV_BUS) v(OVP_SNS) v(VREF_OVP) v(OVP_SET) v(LATCH_B) v(OVP_LATCH) v(COMP_N) v(HV_EN) v(HV_EN_G) v(HV_IN) v(DRV_VDD) v(CS_FILT) i(L20) @q21[ic] @q22[ic] @q25[ic] v(VREF_UC) v(HV_GATE) i(VIN)
wrdata waves.txt v(HV_BUS) v(OVP_SNS) v(VREF_OVP) v(OVP_SET) v(LATCH_B) v(OVP_LATCH) v(COMP_N) v(HV_EN) v(HV_EN_G) v(HV_IN) v(DRV_VDD) v(CS_FILT) i(L20) @q21[ic] @q22[ic] @q25[ic] v(VREF_UC) v(HV_GATE) i(VIN)
quit
.endc
.end
