Sprint04 fixed-PWM hot-start diagnostic - NOT ACTUAL CIRCUIT
.model NSW SW(RON=.55 ROFF=1e10 VT=3 VH=.1)
.model UF D(IS=10n N=1.5 RS=.5 CJO=15p TT=75n BV=1000 IBV=5u)
.model BODY D(IS=1n N=1.5 RS=.1 CJO=1p TT=100n BV=400)
VIN vin 0 24
RL vin lin .3
L20 lin sw 220u IC=0
VSWI sw mos 0
S20 mos src gate src NSW
RSENSE src 0 .15
DBODY src mos BODY
COSS mos src 150p
X20 sw da UF4007
VDPROBE da hv 0
RESR hv cap .5
COUT cap 0 20.3u IC=170
RBLEED hv 0 50k
RFB hv 0 1.5221meg
ROVP hv 0 1.5191meg
RADC hv 0 1.5143meg
BTUBE hv 0 I=27m*min(max(v(hv)/150,0),1)
VPWM gate src PULSE(0 10 0 30n 30n 6.5992882407717954e-06 1.282051282051282e-05)
C10 sw hv 10n
* SPICE model rectifier diode ***UF4007***
* Use the symbol file ***uf4007.asy***
*
* (c) Diotec Semiconductor AG
* www.diotec.com
* 2017-11-23
*
*********************************************************
* This model is for simulation purposes only. It does   *
* not replace reviewing of the data sheet nor real life *
* testing of the part inside the application.           *
*********************************************************
*
.subckt UF4007  A  K  params: Vrrm=1000 Vrsm=1000 Ir=5u Irsm=5u Vf=1.7 Ifav=1 Rs=.11 trr=75n Cj=15p Eg=1.11 Xti=3

* Above values are an example for the ***UF4007***. Using the symbol
* above symbol file allows for direct insertion of other values
* according to these data sheet parameters:
*
* Vrrm    	Repetitive peak reverse voltage
* Ir		Leakage current
* Vrsm    	Surge peak reverse voltage / Reverse avalanche breakdown voltage
* Irsm		Defined at avalanche diodes, otherwise set Irsm = Ir
* Vf		Forward voltage
* Ifav		Test current for Vf, usually equal to average forward rectified current
* trr		Reverse recovery time; for Schottky, set trr=5n
* Cj		Junction capacitance at 4V
*
* Activation energy: Eg=1.11 for Si (pn) rectifier, Eg=.69 for Schottky (metal barrier) rectifier
* Series resistance: Rs=(Vf@3*Ifav - Vf@Ifav)/(3*Ifav - Ifav) from data sheet curve
* Sat.-current temp. exp: Xti=3 for Si (pn) rectifier, Xti=2 for Schottky (metal barrier) rectifier

D  A K  Rectifier

.model Rectifier D(Is={Ir/40} Bv={Vrsm*1.05} Ibv={Ir} Vpk=Vrrm N={.8*Vf/25m/(ln(Ifav)-ln(Ir/40))} Rs={Rs} Eg={Eg} Xti={Xti} Iave={Ifav} Cjo={Cj*2} M=.33 Tt={trr} Vp=.5)

.ends

.options reltol=.001 abstol=1n vntol=1u method=gear itl4=200
.control
set noaskquit
set wr_singlescale
set wr_vecnames
tran 5e-08 0.003 0 5e-08 uic
meas tran end_time MAX time

wrdata waves.txt v(hv) v(cap) v(sw) v(src) v(gate) i(l20) i(vdprobe) v(mos) i(vswi)
quit
.endc
.end
