* B-source self test: buffered node + voltage-controlled current into C
V1 in 0 DC 5
R1 in a 1k
BX buf 0 V = V(a)
BY 0 c I = V(a) / 1000
C1 c 0 1u
R2 c 0 1meg
.tran 2u 1m
.save v(a) v(buf) v(c)
.end
