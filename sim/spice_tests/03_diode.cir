* diode forward conduction: 5 V -> 1k -> D -> GND
V1 in 0 DC 5
R1 in a 1k
D1 a 0 DMOD
.model DMOD D(Is=1e-9 N=1.05)
.tran 1u 2m
.save v(a)
.end
