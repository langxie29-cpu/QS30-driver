* QS30-6 REV.A boost power stage - open loop, DUTY = controller equilibrium duty
* Design operating point: 12 V -> 172 V, 6-tube equivalent load 12.3 k, ~2.6 W (DCM).
* Fixed duty D=0.73 is the DCM duty that gives Vout=172 V at this load
* (DCM boost: M=(1+sqrt(1+4D^2/K))/2, K=2L/(R*Ts)).
* NOTE: ideal capacitors, diode ignores Rs/Cjo, switch = linear-transition model,
*       MOSFET Coss is NOT modelled in the baseline; a 100 pF Coss
*       sensitivity case is generated by replacing the CSW_SLOT line.
.param Vin=12
VIN in 0 DC 12
L1 in swa 220u
RL1 swa sw 0.3
VG g 0 PULSE(0 5 0 20n 20n 9.358974u 12.820513u)
S1 sw 0 g 0 SWMOD
D1 sw out DMOD
* CSW_SLOT
COUT out 0 20u ic=172
RB out 0 200k
RLOAD out 0 12.3k
.model SWMOD VSWITCH(Ron=0.55 Roff=1e6 Von=2.5 Voff=1.0)
.model DMOD D(Is=1e-9 N=1.05)
.tran 20n 150u
.save v(out) v(sw) i(L1) i(VIN) v(g)
.end
