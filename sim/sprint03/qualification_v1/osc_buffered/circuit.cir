UC3843A hypothesis using inherited functional model
.include uc3843_functional.lib
VCC vcc 0 12
VCOMP comp 0 5
VFB fb 0 0
RT ref ct 10k
CT ct 0 2.2n
CREF ref 0 100n
XUC comp fb cs ct 0 out vcc ref UC3843_FUNC IDIS=0.0083
CG out 0 1n
VSRC src 0 0
R36 src cs 1k
C13 cs 0 100p
RRAMP rampbuf cs 2.8k
RBCT ct rbbase 1k
QBUF vcc rbbase rampbuf NBUF
REBUF rampbuf 0 100k
.model NBUF NPN(IS=6.7f BF=100 VAF=75 IKF=.1 CJE=4p CJC=3p TF=.3n)

.options reltol=.001 abstol=1n vntol=1u method=gear itl4=200
.control
set noaskquit
set wr_singlescale
set wr_vecnames
tran 2e-08 0.001 0 2e-08 uic
meas tran end_time MAX time

wrdata waves.txt v(ct) v(out) v(cs) v(ref)
quit
.endc
.end
