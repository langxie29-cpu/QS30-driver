* D:\PROJECTS\dsharness\QS30-power-loop-r1\projects\QS30-9_24V\power_loop_r1\evidence\native_reference_netlist_retry\LT3757A.asc
M°ÏQ1 N001 N005 N006 N006 FDS6680A
R1 N007 0 41.2K
R2 N010 0 16.2K
R3 OUT N010 226K
L1 IN N001 10u
D1 N001 OUT MBR735
C1 OUT 0 47u Rser=.1 x2
R4 N009 N008 22K
C2 N008 0 6800p
V1 IN 0 12
C3 N003 0 4.7u
C4 N004 0 .01u
R5 N002 0 43.2K
R6 IN N002 200K
Rload OUT 0 12
R7 N006 0 .01
XU1 N009 N010 N004 N007 MP_01 N006 N005 N003 N002 IN 0 LT3757A
.model D D
.lib C:\Users\Administrator\AppData\Local\LTspice\lib\cmp\standard.dio
.model NMOS NMOS
.model PMOS PMOS
.lib C:\Users\Administrator\AppData\Local\LTspice\lib\cmp\standard.mos
.tran 1.5m startup
.lib LT3757A.sub
.backanno
.end
