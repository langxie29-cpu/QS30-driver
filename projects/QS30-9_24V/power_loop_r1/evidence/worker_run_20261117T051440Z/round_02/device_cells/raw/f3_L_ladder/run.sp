* F3a L(I) ladder: 9 forced-current branches, 0..8 A through 150 uH
* DCR as a series resistor (ngspice-47 L has no Rser parameter)
.temp 27
I1 0 NLI1 PWL(0 0 1u 0.0 401u 1.0)
R1 NLI1 NLV1 0.038
L1 NLV1 0 150u
I2 0 NLI2 PWL(0 0 1u 1.0 401u 2.0)
R2 NLI2 NLV2 0.038
L2 NLV2 0 150u
I3 0 NLI3 PWL(0 0 1u 2.0 401u 3.0)
R3 NLI3 NLV3 0.038
L3 NLV3 0 150u
I4 0 NLI4 PWL(0 0 1u 3.0 401u 4.0)
R4 NLI4 NLV4 0.038
L4 NLV4 0 150u
I5 0 NLI5 PWL(0 0 1u 4.0 401u 5.0)
R5 NLI5 NLV5 0.038
L5 NLV5 0 150u
I6 0 NLI6 PWL(0 0 1u 5.0 401u 6.0)
R6 NLI6 NLV6 0.038
L6 NLV6 0 150u
I7 0 NLI7 PWL(0 0 1u 6.0 401u 7.0)
R7 NLI7 NLV7 0.038
L7 NLV7 0 150u
I8 0 NLI8 PWL(0 0 1u 7.0 401u 8.0)
R8 NLI8 NLV8 0.038
L8 NLV8 0 150u
I9 0 NLI9 PWL(0 0 1u 8.0 401u 9.0)
R9 NLI9 NLV9 0.038
L9 NLV9 0 150u
.options reltol=1e-4 abstol=1e-12 vntol=1e-8 chgtol=1e-15
.tran 5e-07 0.000402 0 uic

.control
run
wrdata out.dat i(I1) v(NLV1) i(I2) v(NLV2) i(I3) v(NLV3) i(I4) v(NLV4) i(I5) v(NLV5) i(I6) v(NLV6) i(I7) v(NLV7) i(I8) v(NLV8) i(I9) v(NLV9)
.endc
.end
