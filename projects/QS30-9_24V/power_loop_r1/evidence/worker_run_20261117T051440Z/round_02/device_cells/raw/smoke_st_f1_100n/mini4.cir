* mini4
.include stp9nk50z.lib
.temp 27
Vbus b 0 170
Lbus b d 1u
XQ d g s STP9NK50Z
Rs s 0 1m
Vp p 0 PULSE(0 6.5 1u 100n 100n 25u 100u)
Rg p g 10
Rgs g 0 10k
VV 0 d 0
.options reltol=1e-4 gminsteps=0 srcsteps=0
.tran 100n 20u 10u uic
.control
run
print v(d) i(VV) > op.txt
wrdata out4.dat v(d) i(VV)
.endc
.end
