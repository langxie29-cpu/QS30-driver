* name probe
.include stp9nk50z.lib
VG gt1 0 10
VDD drain1 0 5
VS src1 0 0.001
XQ0 d gt1 src1 STP9NK50Z
XQ1 g gt1 src1 STP9NK50Z
XQ2 s gt1 src1 STP9NK50Z
XQ3 VSW gt1 src1 STP9NK50Z
XQ4 VG gt1 src1 STP9NK50Z
XQ5 VSS gt1 src1 STP9NK50Z
XQ6 NVSWP gt1 src1 STP9NK50Z
XQ7 sw1 gt1 src1 STP9NK50Z
XQ8 gt1 gt1 src1 STP9NK50Z
XQ9 src1 gt1 src1 STP9NK50Z
XQ10 ND gt1 src1 STP9NK50Z
XQ11 NG gt1 src1 STP9NK50Z
XQ12 NS gt1 src1 STP9NK50Z
XQ13 drain1 gt1 src1 STP9NK50Z
XQ14 gate1 gt1 src1 STP9NK50Z
XQ15 srcnode gt1 src1 STP9NK50Z
XQ16 n1 gt1 src1 STP9NK50Z
XQ17 n2 gt1 src1 STP9NK50Z
XQ18 n3 gt1 src1 STP9NK50Z
XQ19 xh1 gt1 src1 STP9NK50Z
XQ20 xq1 gt1 src1 STP9NK50Z
XQ21 N001 gt1 src1 STP9NK50Z
XQ22 N005 gt1 src1 STP9NK50Z
XQ23 MP_1 gt1 src1 STP9NK50Z
VV 0 src1 0
.op

.control
run
print i(VDD)
.endc
.end
