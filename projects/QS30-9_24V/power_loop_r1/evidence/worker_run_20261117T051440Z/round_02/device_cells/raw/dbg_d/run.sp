* diode turn-off
.include us1g_vishay1999.models
.model DCAND D(PWL)
.temp 27
Vf VFP 0 10
Rf VFP NVFP 1
Lf NVFP NVAP 100u IC=1
X1 NVAP NVKP DCAND
Vr NVKP 0 PWL(0 0 2u 0 2.195u 195 20u 195 20.195u 0 40u 0)
.options reltol=1e-4
.tran 2e-08 4e-05 0 uic

.control
run
wrdata out.dat i(Vf) v(NVKP) v(NVAP,NVKP)
.endc
.end
