* mini2
.include stp9nk50z.lib
.temp 27
Vbus b 0 170
Lbus b d 1u
XQ d g s STP9NK50Z
Rs s 0 1m
L2 d2 0 150u
Ds d2 d DUF
Vp p 0 PULSE(0 6.5 1u 100n 100n 25u 100u)
Rg p g 10
Rgs g 0 10k
.model DUF D(IS=1e-9 N=1.7 RS=0.05 BV=1000 CJO=20p TT=100n)
.options reltol=1e-4
.tran 100n 20u 10u uic
.control
wrdata out2.dat v(d) i(Lbus)
.endc
.end
