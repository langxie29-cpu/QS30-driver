* topo
.include stp9nk50z.lib
VG NVGP 0 10
VDD an_d 0 5
VV 0 NVSSP 0
XQ an_d NVGP NVSSP STP9NK50Z
.op

.control
run
showmod
print i(VDD)
.endc
.end
