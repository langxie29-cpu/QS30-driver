* B F1 v3
.include stp9nk50z.lib
.temp 27
Vbus b 0 170
XQ d g s STP9NK50Z
Rs s 0 1m
L2 d 0 150u IC=0
Vp p 0 PULSE(0 6.5 1u 100n 100n 25u 100u)
Rg p g 10
Rgs g 0 10k
VV 0 s 0
.nodeset v(d)=170 v(g)=0
.options reltol=1e-4
.tran 100n 200u 190u uic

.control
run
wrdata out.dat v(d) i(VV) v(g)
.endc
.end
