* reverse window -250 V .. 0 V
.include us1g_diodesinc.models
.model DI_US1G D
.temp 125
VA NVAP 0 0
D1 NVAP NVKP DI_US1G
VK NVKP 0 0
.dc VA -250 0 0.5

.control
run
wrdata out.dat i(VA)
.endc
.end
