* Replay of ORIGINAL TI PSpice transient fixture (startup) in ngspice-47
* vendor netlist bytes: UCC28C43_STARTUP.net sha256 verbatim component lines
* component lines are transcribed verbatim from the TI-generated .net; only the analysis shell differs:
*   TI .cir .LIB ../../../ucc28c43.lib  ->  .include ucc28c43_trans_unencrypted.lib (identical content, sha in metrics)
*   TI .TRAN/.OPTIONS (PSpice ABSTOL=1u CHGTOL=0.1p GMIN=1e-10 ITL4=5000 RELTOL=0.01 VNTOL=1m)
*     -> ngspice tolerances listed in .options below (ngspice has no CHGTOL)
*   TI V_V1 has NO source specification -> V_V1 VIN 0 24 (explicit assumption, see metrics)
*   TI .IC V(FB )=2.5 -> ngspice .nodeset V(FB)=2.5 (same DC initial operating point guess)
*   PSpice SCHEDULE() has no ngspice equivalent -> fixed max step
*   TI node name '+VOUT1' is not a legal ngspice vector name -> wrdata requests it by index find()
.include ucc28c43_trans_unencrypted.lib
.options reltol=0.01 abstol=1u vntol=1m gmin=1e-10 itl4=5000
.nodeset V(FB)=2.5
* source UCC28C43
R_R13         0 N16765917  10k
R_R1         RTCT VREF  13.7k
R_R7         N167661471 VIN  37.4k
X_U7         N16765447 N16765917 N16765417 FQB6N80
C_C10         0 VIN  0.15uF
C_C1         RTCT N16764805  470pF
D_D6         N16765857 +VOUT1 ES3B
R_R2         N16764805 0  24
C_C17         VDD 0  0.1u IC=17
R_R16         N16764549 0  39k
R_R25         0 +VOUT2  480
R_R19         0 N16764579  40m
D_D8         +VOUT2 VDD D1N4148
D_D4         N16765561 N167645131 ES3B
C_C16         VDD 0  1uF IC=17
R_R17         N167645131 +VOUT2  10
R_R8         VDD N167661471  37.4k
C_C8         VREF 0  0.1uF
R_R15         N16765857 N167657290  78.7
C_C18         +VOUT1 N16764579  47uF IC=12
X_U2         N16765599 N16765447 0 N16766251 XFMR PARAMS: RATIO=0.16667
V_V1         VIN 0
+PULSE 0 100 10u 200u 200u 1 2
R_R21         N16766251 N16765857  0.5
C_C9         N16765701 N16765561  150pF
C_C12         N167657290 +VOUT1  150pF
R_R9         0 +VOUT2  4.42k
C_C5         CS 0  330pF
R_R18         0 +VOUT1  8.2k
X_U3         N16765599 N16765447 0 N16766297 XFMR PARAMS: RATIO=0.16667
R_R20         0 N16765327  40m
R_R4         FB +VOUT2  15k
R_R22         N16766297 N16765561  0.5
C_C14         +VOUT1 0  0.1uF IC=12
C_C19         +VOUT2 N16765327  47uF IC=12
C_C2         VIN 0  10uF
R_R10         CS N16765417  1k
R_R5         0 FB  3.9k
R_R11         N16765701 +VOUT2  78.7
L_L1         N16765599 N16765447  300uH
R_R23         VIN N16765599  1.2
C_C4         N16764823 COMP  56000pF
C_C15         COMP FB  56pF
C_C11         N16765447 N16764549  220pF
R_R26         0 +VOUT1  48
R_R6         FB N16764823  57.6k
X_U5         0 VDD DI_SMAZ16
X_U8         COMP FB CS RTCT 0 OUT VDD VREF UCC28C43_STEADY
R_R14         0 N16765417  1.6
R_R12         OUT N16765917  10
D_D5         N16764549 0 DI_S1K

.control
set noaskquit
set wr_singlescale
set wr_vecnames
tran 2e-08 0.009 0.005 2e-08
meas tran native_end MAX time
let j = @v_v1[i]
wrdata waves.txt v(vdd) v(vin) v(out) v(cs) v(comp) v(fb) v(vref) v(rtct) v(j)
echo ---- ALL VECTOR NAMES ----
display
settype tran
option ascii
write raw_all.txt all
quit
.endc
.end
