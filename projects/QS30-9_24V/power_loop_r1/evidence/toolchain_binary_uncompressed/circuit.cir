Native solver RC check, not HV qualification
V1 in 0 1
R1 in out 1k
C1 out 0 1n IC=0
.options numdgt=15 plotwinsize=0
.tran .5n 1u 0 .5n uic
.save V(out)
.end
