Native solver RC check, not HV qualification
V1 in 0 1
R1 in out 1k
C1 out 0 1n IC=0
.control
tran .5n 1u uic
set wr_singlescale
set wr_vecnames
wrdata waves.txt v(out)
quit
.endc
.end
