S06 independent UCC27511 driver switch
.include driver.lib
VDD vdd 0 PWL(0 0 1u 11.4 100u 11.4)
VIN inp 0 PULSE(0 3.3 10u 2n 2n 20u 40u)
VIM inm 0 0
XD inp inm 0 vdd dh dl UCC27511_TRANS
RGON dh gate 10
RGOFF dl gate 2.2
RGS gate 0 10k
CG gate 0 5.333333n
.options reltol=.001 abstol=1n vntol=1u method=gear itl4=200
.control
set noaskquit
set wr_singlescale
set wr_vecnames
tran 1e-09 100u 0 1e-09 uic
meas tran native_end MAX time
wrdata waves.txt v(inp) v(inm) v(gate)
echo unit_finished
.endc
.end
