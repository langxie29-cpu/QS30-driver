Gate charge isolated device characterization, no boost workpoint
.include vendor.lib
XQ drain gate 0 SiHP8N50D
ID 0 drain 4
VCL cl 0 400
DCL drain cl CLAMP
VGL gl 0 12
DGL gate gl CLAMP
.model CLAMP D(IS=1p N=1 RS=.1 EG=0 XTI=0)
IG 0 gate PULSE(0 1m 1u 1n 1n 100u 200u)
RGDC gate 0 1Meg
.temp 100
.options tnom=25 reltol=.001 abstol=1n vntol=1u method=gear itl4=200

.tran 2.5n 40u 0 2.5n
.save V(gate) V(drain) I(VCL)
.options plotwinsize=0 numdgt=15
.end
