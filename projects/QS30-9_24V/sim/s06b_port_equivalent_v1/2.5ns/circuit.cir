S06 TI UCC28C43 standalone cs_gate_buffered
.include vendor.lib
VDD vdd 0 PWL(0 0 1u 12 500u 12)
VFB fb 0 0
VCS cs 0 PULSE(0 1.2 300u 1n 1n 50u 100u)
XU comp fb cs ct 0 out vdd vref UCC28C43_START
RT vref ct 15.4k
CT ct 0 1n
CVREF vref 0 100n
CCOMP comp 0 1n
COUT out 0 1p
.include driver_compat.lib
VINHIBIT inhibit 0 PULSE(0 3.3 375u 1n 1n 20u 1m)
RPORT out 0 230k
BPORT din 0 V=V(out)
XD din inhibit 0 vdd dh dl UCC27511_TRANS
RGON dh gate 10
RGOFF dl gate 2.2
CG gate 0 5.333333n
RGS gate 0 10k

.options reltol=.001 abstol=1n vntol=1u method=gear itl4=200
.control
set noaskquit
set wr_singlescale
set wr_vecnames
tran 2.5e-09 500u 0 2.5e-09 uic
meas tran native_end MAX time
wrdata waves.txt v(vdd) v(vref) v(ct) v(out) v(cs) v(comp) v(gate)
quit
.endc
.end
