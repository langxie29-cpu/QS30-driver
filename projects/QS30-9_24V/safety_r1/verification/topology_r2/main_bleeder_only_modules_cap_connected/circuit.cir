Safety R1 low-voltage topology main_bleeder_only_modules_cap_connected
C1 bus 0 2.1315e-05 IC=24
R1 bus 0 202000.0

.options reltol=.0001 abstol=1n vntol=1u
.control
set noaskquit
set numdgt=15
set wr_singlescale
set wr_vecnames
tran 0.001 6 uic
wrdata waves.txt v(bus)
quit
.endc
.end
