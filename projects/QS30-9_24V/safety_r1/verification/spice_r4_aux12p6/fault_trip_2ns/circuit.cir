Safety R1 isolated real TI driver fault_trip
.include driver.lib
VDD vdd 0 PWL(0 0 1u 12.6 20u 12.6)
VIN inp 0 PWL(0 0 2u 0 2.001u 3.3 20u 3.3)
VIM inm 0 PWL(0 3.3 4.999u 3.3 5u 0 11.999u 0 12u 3.3 20u 3.3)
XD inp inm 0 vdd dh dl UCC27511_TRANS
RGON dh gate 10
RGOFF dl gate 2.2
RGS gate 0 10k
CG gate 0 5.333333n
.options reltol=.001 abstol=1n vntol=1u method=gear itl4=200
.control
set noaskquit
set wr_singlescale
set wr_vecnames
set numdgt=15
tran 2n 20u 0 2n uic
wrdata waves.txt v(vdd) v(inp) v(inm) v(gate)
quit
.endc
.end
