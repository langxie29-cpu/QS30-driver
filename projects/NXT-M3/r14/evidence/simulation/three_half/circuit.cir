R14 cathode proxy, (195, 0, True, 'off', 19800, 1000000000000.0, 3)
VSOURCE src 0 195
VSENSE src hv 0
CHV hv 0 3.63u ic=195
RBLEED1 hv 0 500960
RBLEED2 hv 0 500960
.model QPROXY NPN(IS=1e-14 BF=60 VAF=80 BR=2 IKF=.05)
.model DPLASMA D(IS=1e-8 N=1 RS=1)
.model DCLAMP D(IS=1e-12 N=1 RS=2)
VLOGIC logic 0 0
RA1 hv ta1 19800
VTA1 ta1 ti1 0
DT1 ti1 tk1 DPLASMA
VIAN1 tk1 c1 0
VDRV1 d1 0 0
ROUT1 d1 out1 50

RBASE1 out1 b1 3000
RPD1 b1 0 10000
VB1 b1 bq1 0
VC1 c1 cq1 0
Q1 cq1 bq1 0 QPROXY
RCE1 c1 0 19800
RCB1 c1 b1 1000000000000.0
RA2 hv ta2 19800
VTA2 ta2 ti2 0
DT2 ti2 tk2 DPLASMA
VIAN2 tk2 c2 0
VDRV2 d2 0 0
ROUT2 d2 out2 50

RBASE2 out2 b2 3000
RPD2 b2 0 10000
VB2 b2 bq2 0
VC2 c2 cq2 0
Q2 cq2 bq2 0 QPROXY
RCE2 c2 0 19800
RCB2 c2 b2 1000000000000.0
RA3 hv ta3 19800
VTA3 ta3 ti3 0
DT3 ti3 tk3 DPLASMA
VIAN3 tk3 c3 0
VDRV3 d3 0 0
ROUT3 d3 out3 50

RBASE3 out3 b3 3000
RPD3 b3 0 10000
VB3 b3 bq3 0
VC3 c3 cq3 0
Q3 cq3 bq3 0 QPROXY
RCE3 c3 0 19800
RCB3 c3 b3 1000000000000.0
BVCE vce 0 V=v(c1)
BVBE vbe 0 V=v(bq1)
BIB ib 0 V=i(VB1)
BIC ic 0 V=i(VC1)
BIA ianode 0 V=i(VIAN1)
BPQ pq 0 V=v(c1)*i(VC1)+v(bq1)*i(VB1)
BPCE pce 0 V=v(c1)*v(c1)/19800
BPCB pcb 0 V=(v(c1)-v(b1))*(v(c1)-v(b1))/1000000000000.0
BP pdut 0 V=v(pq)+v(pce)+v(pcb)
BBK eback 0 V=i(VLOGIC)
BIS isupply 0 V=i(VSENSE)
.tran 2m 4 0 2m uic
.save v(hv) v(vce) v(vbe) v(ib) v(ic) v(ianode) v(pq) v(pce) v(pcb) v(pdut) v(eback) v(isupply)
.end
