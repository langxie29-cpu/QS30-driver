R14 cathode proxy, (170, 0, True, 'on', 1000000000000.0, 1000000000000.0, 0)
VSOURCE src 0 170
VSENSE src hv 0
CHV hv 0 3.63u ic=170
RBLEED1 hv 0 500960
RBLEED2 hv 0 500960
.model QPROXY NPN(IS=1e-14 BF=60 VAF=80 BR=2 IKF=.05)
.model DPLASMA D(IS=1e-8 N=1 RS=1)
.model DCLAMP D(IS=1e-12 N=1 RS=2)
VLOGIC logic 0 0
RA1 hv ta1 1000000000000.0
VTA1 ta1 ti1 0
DT1 ti1 tk1 DPLASMA
VIAN1 tk1 c1 0
VDRV1 d1 0 3.3
ROUT1 d1 out1 50

RBASE1 out1 b1 3000
RPD1 b1 0 10000
VB1 b1 bq1 0
VC1 c1 cq1 0
Q1 cq1 bq1 0 QPROXY
RCE1 c1 0 1000000000000.0
RCB1 c1 b1 1000000000000.0
BVCE vce 0 V=v(c1)
BVBE vbe 0 V=v(bq1)
BIB ib 0 V=i(VB1)
BIC ic 0 V=i(VC1)
BIA ianode 0 V=i(VIAN1)
BPQ pq 0 V=v(c1)*i(VC1)+v(bq1)*i(VB1)
BPCE pce 0 V=v(c1)*v(c1)/1000000000000.0
BPCB pcb 0 V=(v(c1)-v(b1))*(v(c1)-v(b1))/1000000000000.0
BP pdut 0 V=v(pq)+v(pce)+v(pcb)
BBK eback 0 V=i(VLOGIC)
BIS isupply 0 V=i(VSENSE)
.tran 2m 4 0 2m uic
.save v(hv) v(vce) v(vbe) v(ib) v(ic) v(ianode) v(pq) v(pce) v(pcb) v(pdut) v(eback) v(isupply)
.end
